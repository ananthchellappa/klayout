.subckt TOP sky130_gnd
XM1 d g s sky130_gnd sky130_fd_pr__nfet_01v8 L=0.15 W=1 nf=1 m=1
.ends
